.title KiCad schematic
.model __D1 D
.model __D5 D
.model __D6 D
ConnView_OutInfo1 __ConnView_OutInfo1
Button1_a2 __Button1_a2
Button1_b1 __Button1_b1
Button1_a1 __Button1_a1
Button1_b2 __Button1_b2
R20 Net-_Q3-B_ Net-_Button1_b2-Pin_1_ R
U10 __U10
C5 GND Net-_Q4-B_ C
R15 Net-_Q3-B_ Net-_Button1_b1-Pin_1_ R
ConnView_Out5 __ConnView_Out5
R6 GND Net-_ConnView_Out5-Pin_1_ R
R13 Net-_ConnView_Out5-Pin_1_ /V15 R
U6 __U6
C6 Net-_ConnView_Out2-Pin_1_ Net-_ConnView_Out3-Pin_1_ C
C1 Net-_U6A-+_ GND C
R10 GND Net-_ConnView_Out3-Pin_1_ R
R5 Net-_U2B--_ Net-_U6A-+_ R
C7 Net-_C7-Pad1_ Net-_U9A--_ C
U9 __U9
R8 Net-_C7-Pad1_ Net-_U6B--_ R
D1 Net-_D1-A_ Net-_Button1_a1-Pin_1_ __D1
ConnView_Out4 __ConnView_Out4
R14 Net-_ConnView_Out4-Pin_1_ Net-_U9A--_ R
C13 Net-_U2B-+_ GND C
R37 Net-_R37-Pad1_ Net-_U2B-+_ R
C10 Net-_U9A--_ Net-_ConnView_Out4-Pin_1_ C
U2 __U2
Y1 __Y1
C_G1 GND Net-_U7-PH0_ C
C_G2 GND Net-_U7-PH1_ C
ConnProgramator1 __ConnProgramator1
R28 GND Net-_Q3-E_ R
Q2 Net-_Q2-E_ Net-_Q2-B_ /V5 2N3904
R26 Net-_Q3-E_ /V5 R
Q3 Net-_Q3-E_ Net-_Q3-B_ Net-_Q3-C_ 2N3906
R21 Net-_Q2-E_ Net-_R21-Pad2_ R
R19 Net-_Q2-B_ Net-_Button1_b2-Pin_1_ R
U18 __U18
U3 __U3
R1 /V5 /SCL 4.7k
R2 /V5 /SDA 4.7k
U7 __U7
U19 __U19
U8 __U8
C3 Net-_U2A-+_ GND C
R36 GND Net-_U2A--_ R
R39 GND Net-_Q1-E_ R
R7 Net-_Q1-E_ Net-_U2A-+_ R
Button2_a2 __Button2_a2
Button2_b2 __Button2_b2
Button2_a1 __Button2_a1
Button2_b1 __Button2_b1
R16 Net-_R16-Pad1_ GND R
R9 Net-_D5-A_ GND R
D5 Net-_D5-A_ Net-_Button2_b2-Pin_1_ __D5
D6 Net-_D5-A_ Net-_Button2_b1-Pin_1_ __D6
R17 Net-_U15A-+_ Net-_U15B--_ R
R22 Net-_U15B--_ Net-_R22-Pad2_ R
U15 __U15
R43 Net-_Q5-E_ GND R
U14 __U14
R27 Net-_Q3-C_ Net-_R27-Pad2_ R
U12 __U12
U13 __U13
ConnView_Modulation1 __ConnView_Modulation1
R31 Net-_R30-Pad2_ Net-_U13B--_ R
U16 __U16
U17 __U17
R32 Net-_U13B--_ Net-_ConnView_Modulation1-Pin_1_ R
ConnView_OutLast1 __ConnView_OutLast1
R24 Net-_R11-Pad2_ Net-_ConnView_Modulation1-Pin_1_ R
R45 Net-_Q4-E_ GND R
R25 Net-_U14A-DIODE_BIAS_ /V15 R
R34 Net-_Q4-E_ GND R
Q4 Net-_Q4-E_ Net-_Q4-B_ /V15 2N3904
R35 /V15 Net-_Q4-E_ R
R44 /V15 Net-_Q5-C_ R
R18 __R18
Q5 Net-_Q5-E_ Net-_Q4-E_ Net-_Q5-C_ 2N3904
R29 Net-_Q5-E_ Net-_U13A--_ R
R30 Net-_U13A--_ Net-_R30-Pad2_ R
U11 __U11
R4 Net-_ConnView_OutInfo1-Pin_1_ Net-_U14A--_ R
R3 Net-_U14A-+_ Net-_U14A--_ R
R23 /V15m Net-_U15A-+_ R
R11 Net-_ConnView_OutInfo1-Pin_1_ Net-_R11-Pad2_ R
Q1 Net-_Q1-E_ Net-_ConnView_Out1-Pin_1_ Net-_Q1-C_ 2N3904
R38 Net-_U2A--_ Net-_R37-Pad1_ R
ConnView_Out1 __ConnView_Out1
C14 /V15 GND C
ConnView_Out3 __ConnView_Out3
ConnView_Out2 __ConnView_Out2
J1 __J1
R42 GND Net-_ConnView_Out1-Pin_1_ R
R41 Net-_ConnView_Out1-Pin_1_ /V15 R
R40 Net-_Q1-C_ /V15 R
.end
